| / 7\'7
| \ \   Xilinx Inc.
| / /
| \_\/.\   IBIS Models for ARTIX7 IO
[IBIS ver]   4.2
[File name]   rv32imacb_zicsr_zifencei_zbc-ibis_model.ibs
[File Rev]   2.8
[Date]   Sat January 10 23:22:23 2026
[Source]   Derived from spice models, rev1.0, using
   hspice 2010.03-ENG2
[Notes]   Xilinx IBIS file for ARTIX7 I/O standards.
   All models are preliminary.
   The version of IBISCHK used is ibischk5.
   Ibis models were generated using S2IBIS3.
[Disclaimer] The data in this file is derived from SPICE simulations using
                 modeling information extracted from the target process.
                 A great deal of care has been taken to provide information
                 that is accurate. This model has been verified by actual silicon
                 measurement.
[Copyright]   Copyright 2012-2017, Xilinx Inc., All rights reserved
|   Component ARTIX7
[Component]   ARTIX7
[Manufacturer]   Xilinx Inc.
[Package]
|CSG324
|variable   typ   min   max
R_pkg   346.33m   108.28m   584.38m
L_pkg   5.907nH   1.89nH   9.93nH
C_pkg   1.14pF   0.338pF   1.935pF
[Pin]   signal_name   model_name  R_pin  L_pin  C_pin
A1   IO_L9N_T1_DQS_AD7N_35   NC
A2   GND   GND
A3   IO_L8N_T1_AD14N_35   NC
A4   IO_L8P_T1_AD14P_35   NC
A5   IO_L3N_T0_DQS_AD5N_35   NC
A6   IO_L3P_T0_DQS_AD5P_35   NC
A7   VCCO_35   POWER
A8   dip_switches_4bits_tri_i[0]   LVCMOS33_S_8_HR
A9   usb_uart_rxd   LVCMOS33_S_8_HR
A10   dip_switches_4bits_tri_i[3]   LVCMOS33_S_8_HR
A11   IO_L4N_T0_15   NC
A12   GND   GND
A13   i2c_pullups_tri_o[1]   LVCMOS33_S_12_HR
A14   i2c_pullups_tri_o[0]   LVCMOS33_S_12_HR
A15   IO_L8P_T1_AD10P_15   NC
A16   IO_L8N_T1_AD10N_15   NC
A17   VCCO_15   POWER
A18   IO_L10N_T1_AD11N_15   NC
B1   IO_L9P_T1_DQS_AD7P_35   NC
B2   IO_L10N_T1_AD15N_35   NC
B3   IO_L10P_T1_AD15P_35   NC
B4   IO_L7N_T1_AD6N_35   NC
B5   GND   GND
B6   IO_L2N_T0_AD12N_35   NC
B7   IO_L2P_T0_AD12P_35   NC
B8   push_buttons_4bits_tri_i[3]   LVCMOS33_S_8_HR
B9   push_buttons_4bits_tri_i[2]   LVCMOS33_S_8_HR
B10   VCCO_16   POWER
B11   IO_L4P_T0_15   NC
B12   IO_L3N_T0_DQS_AD1N_15   NC
B13   IO_L2P_T0_AD8P_15   NC
B14   IO_L2N_T0_AD8N_15   NC
B15   GND   GND
B16   IO_L7P_T1_AD2P_15   NC
B17   IO_L7N_T1_AD2N_15   NC
B18   IO_L10P_T1_AD11P_15   NC
C1   shield_dp0_dp19_tri_io[10]   LVCMOS33_S_12_HR
C2   reset   LVCMOS33_S_8_HR
C3   VCCO_35   POWER
C4   IO_L7P_T1_AD6P_35   NC
C5   IO_L1N_T0_AD4N_35   NC
C6   IO_L1P_T0_AD4P_35   NC
C7   shield_dp0_dp19_tri_io[16]   LVCMOS33_S_12_HR
C8   GND   GND
C9   push_buttons_4bits_tri_i[1]   LVCMOS33_S_8_HR
C10   dip_switches_4bits_tri_i[2]   LVCMOS33_S_8_HR
C11   dip_switches_4bits_tri_i[1]   LVCMOS33_S_8_HR
C12   IO_L3P_T0_DQS_AD1P_15   NC
C13   VCCO_15   POWER
C14   IO_L1N_T0_AD0N_15   NC
C15   IO_L12N_T1_MRCC_15   NC
C16   eth_mii_rst_n   LVCMOS33_S_12_HR
C17   eth_mii_rx_er   LVCMOS33_S_8_HR
C18   GND   GND
D1   GND   GND
D2   IO_L14N_T2_SRCC_35   NC
D3   IO_L12N_T1_MRCC_35   NC
D4   IO_L11N_T1_SRCC_35   NC
D5   shield_dp0_dp19_tri_io[19]   LVCMOS33_S_12_HR
D6   VCCO_35   POWER
D7   shield_dp0_dp19_tri_io[18]   LVCMOS33_S_12_HR
D8   shield_dp0_dp19_tri_io[15]   LVCMOS33_S_12_HR
D9   push_buttons_4bits_tri_i[0]   LVCMOS33_S_8_HR
D10   usb_uart_txd   LVCMOS33_S_12_HR
D11   GND   GND
D12   IO_L6P_T0_15   NC
D13   IO_L6N_T0_VREF_15   NC
D14   IO_L1P_T0_AD0P_15   NC
D15   IO_L12P_T1_MRCC_15   NC
D16   VCCO_15   POWER
D17   eth_mii_col   LVCMOS33_S_8_HR
D18   eth_mii_rxd[0]   LVCMOS33_S_8_HR
E1   rgb_led_tri_o[0]   LVCMOS33_S_12_HR
E2   IO_L14P_T2_SRCC_35   NC
E3   sys_clock   LVCMOS33_S_8_HR
E4   GND   GND
E5   IO_L5N_T0_AD13N_35   NC
E6   IO_L5P_T0_AD13P_35   NC
E7   shield_dp0_dp19_tri_io[17]   LVCMOS33_S_12_HR
E8   VCCBATT_0   LVCMOS18_F_12_HR
E9   CCLK_0   LVCMOS18_F_12_HR
E10   TCK_0   LVCMOS18_F_12_HR
E11   TDI_0   LVCMOS18_F_12_HR
E12   TMS_0   LVCMOS18_F_12_HR
E13   TDO_0   LVCMOS18_F_12_HR
E14   GND   GND
E15   IO_L11P_T1_SRCC_15   NC
E16   IO_L11N_T1_SRCC_15   NC
E17   eth_mii_rxd[1]   LVCMOS33_S_8_HR
E18   eth_mii_rxd[2]   LVCMOS33_S_8_HR
F1   spi_sck_io   LVCMOS33_S_12_HR
F2   VCCO_35   POWER
F3   IO_L13N_T2_MRCC_35   NC
F4   IO_L13P_T2_MRCC_35   NC
F5   shield_dp0_dp19_tri_io[14]   LVCMOS33_S_12_HR
F6   rgb_led_tri_o[1]   LVCMOS33_S_12_HR
F7   GND   GND
F8   VCCINT   POWER
F9   GND   GND
F10   VCCBRAM   POWER
F11   GND   GND
F12   VCCAUX   POWER
F13   IO_L5P_T0_AD9P_15   NC
F14   IO_L5N_T0_AD9N_15   NC
F15   eth_mii_rx_clk   LVCMOS33_S_8_HR
F16   eth_mdio_mdc_mdc   LVCMOS33_S_12_HR
F17   GND   GND
F18   A16   LVCMOS25_F_8_HR
G1   spi_io1_io   LVCMOS33_S_12_HR
G2   IO_L15N_T2_DQS_35   NC
G3   rgb_led_tri_o[5]   LVCMOS33_S_12_HR
G4   rgb_led_tri_o[3]   LVCMOS33_S_12_HR
G5   VCCO_35   POWER
G6   rgb_led_tri_o[2]   LVCMOS33_S_12_HR
G7   VCCINT   POWER
G8   GND   GND
G9   VCCINT   POWER
G10   GND   GND
G11   VCCBRAM   POWER
G12   GND   GND
G13   IO_0_15   NC
G14   eth_mii_crs   LVCMOS33_S_8_HR
G15   VCCO_15   POWER
G16   eth_mii_rx_dv   LVCMOS33_S_8_HR
G17   eth_mii_rxd[3]   LVCMOS33_S_8_HR
G18   A17   LVCMOS25_F_8_HR
H1   spi_io0_io   LVCMOS33_S_12_HR
H2   IO_L15P_T2_DQS_35   NC
H3   GND   GND
H4   rgb_led_tri_o[6]   LVCMOS33_S_12_HR
H5   led_4bits_tri_o[0]   LVCMOS33_S_12_HR
H6   rgb_led_tri_o[10]   LVCMOS33_S_12_HR
H7   GND   GND
H8   VCCINT   POWER
H9   GNDADC_0   NC
H10   VCCADC_0   NC
H11   GND   GND
H12   VCCAUX   POWER
H13   GND   GND
H14   eth_mii_txd[0]   LVCMOS33_S_12_HR
H15   eth_mii_tx_en   LVCMOS33_S_12_HR
H16   eth_mii_tx_clk   LVCMOS33_S_8_HR
H17   eth_mii_txd[3]   LVCMOS33_S_12_HR
H18   VCCO_15   POWER
J1   VCCO_35   POWER
J2   rgb_led_tri_o[7]   LVCMOS33_S_12_HR
J3   rgb_led_tri_o[8]   LVCMOS33_S_12_HR
J4   rgb_led_tri_o[4]   LVCMOS33_S_12_HR
J5   led_4bits_tri_o[1]   LVCMOS33_S_12_HR
J6   GND   GND
J7   VCCINT   POWER
J8   GND   GND
J9   VREFN_0   NC
J10   VP_0   NC
J11   VCCINT   POWER
J12   GND   GND
J13   eth_mii_txd[2]   LVCMOS33_S_12_HR
J14   eth_mii_txd[1]   LVCMOS33_S_12_HR
J15   RS0   LVCMOS25_F_8_HR
J16   GND   GND
J17   FOE_B   LVCMOS25_F_8_HR
J18   FWE_B   LVCMOS25_F_8_HR
K1   rgb_led_tri_o[11]   LVCMOS33_S_12_HR
K2   rgb_led_tri_o[9]   LVCMOS33_S_12_HR
K3   IO_L2P_T0_34   NC
K4   VCCO_34   POWER
K5   IO_L5P_T0_34   NC
K6   IO_0_34   NC
K7   GND   GND
K8   VCCINT   POWER
K9   VN_0   NC
K10   VREFP_0   NC
K11   GND   GND
K12   VCCAUX   POWER
K13   eth_mdio_mdc_mdio_io   LVCMOS33_S_12_HR
K14   VCCO_15   POWER
K15   RS1   LVCMOS25_F_8_HR
K16   IO_25_15   NC
K17   qspi_flash_io0_io   LVCMOS33_S_12_HR
K18   qspi_flash_io1_io   LVCMOS33_S_12_HR
L1   IO_L1P_T0_34   NC
L2   GND   GND
L3   IO_L2N_T0_34   NC
L4   IO_L5N_T0_34   NC
L5   IO_L6N_T0_VREF_34   NC
L6   IO_L6P_T0_34   NC
L7   VCCINT   POWER
L8   GND   GND
L9   DXN_0   NC
L10   DXP_0   NC
L11   VCCINT   POWER
L12   GND   GND
L13   qspi_flash_ss_io   LVCMOS33_S_12_HR
L14   qspi_flash_io2_io   LVCMOS33_S_12_HR
L15   PUDC_B   LVCMOS25_F_8_HR
L16   qspi_flash_sck_io   LVCMOS33_S_12_HR
L17   VCCO_14   POWER
L18   i2c_scl_io   LVCMOS33_S_12_HR
M1   IO_L1N_T0_34   NC
M2   IO_L4N_T0_34   NC
M3   IO_L4P_T0_34   NC
M4   IO_L16P_T2_34   NC
M5   GND   GND
M6   IO_L18P_T2_34   NC
M7   GND   GND
M8   VCCINT   POWER
M9   GND   GND
M10   VCCINT   POWER
M11   GND   GND
M12   VCCAUX   POWER
M13   shield_dp26_dp41_tri_io[2]   LVCMOS33_S_12_HR
M14   qspi_flash_io3_io   LVCMOS33_S_12_HR
M15   GND   GND
M16   shield_dp0_dp19_tri_io[9]   LVCMOS33_S_12_HR
M17   D15   LVCMOS25_F_8_HR
M18   i2c_sda_io   LVCMOS33_S_12_HR
N1   IO_L3N_T0_DQS_34   NC
N2   IO_L3P_T0_DQS_34   NC
N3   VCCO_34   POWER
N4   IO_L16N_T2_34   NC
N5   IO_L13P_T2_MRCC_34   NC
N6   IO_L18N_T2_34   NC
N7   VCCINT   POWER
N8   GND   GND
N9   VCCINT   POWER
N10   GND   GND
N11   VCCINT   POWER
N12   GND   GND
N13   VCCO_14   POWER
N14   shield_dp26_dp41_tri_io[10]   LVCMOS33_S_12_HR
N15   shield_dp0_dp19_tri_io[8]   LVCMOS33_S_12_HR
N16   shield_dp26_dp41_tri_io[9]   LVCMOS33_S_12_HR
N17   shield_dp26_dp41_tri_io[15]   LVCMOS33_S_12_HR
N18   GND   GND
P1   GND   GND
P2   IO_L15P_T2_DQS_34   NC
P3   IO_L14N_T2_SRCC_34   NC
P4   IO_L14P_T2_SRCC_34   NC
P5   IO_L13N_T2_MRCC_34   NC
P6   VCCO_34   POWER
P7   INIT_B_0   LVCMOS18_F_12_HR
P8   CFGBVS_0   LVCMOS18_F_12_HR
P9   PROGRAM_B_0   LVCMOS18_F_12_HR
P10   DONE_0   LVCMOS18_F_12_HR
P11   M2_0   LVCMOS18_F_12_HR
P12   M0_0   LVCMOS18_F_12_HR
P13   M1_0   LVCMOS18_F_12_HR
P14   shield_dp0_dp19_tri_io[2]   LVCMOS33_S_12_HR
P15   shield_dp26_dp41_tri_io[7]   LVCMOS33_S_12_HR
P16   VCCO_14   POWER
P17   shield_dp0_dp19_tri_io[13]   LVCMOS33_S_12_HR
P18   shield_dp26_dp41_tri_io[14]   LVCMOS33_S_12_HR
R1   IO_L17P_T2_34   NC
R2   IO_L15N_T2_DQS_34   NC
R3   IO_L11P_T1_SRCC_34   NC
R4   GND   GND
R5   IO_L19N_T3_VREF_34   NC
R6   IO_L19P_T3_34   NC
R7   IO_L23P_T3_34   NC
R8   IO_L24P_T3_34   NC
R9   VCCO_0   POWER
R10   shield_dp26_dp41_tri_io[3]   LVCMOS33_S_12_HR
R11   shield_dp26_dp41_tri_io[4]   LVCMOS33_S_12_HR
R12   shield_dp0_dp19_tri_io[4]   LVCMOS33_S_12_HR
R13   shield_dp26_dp41_tri_io[5]   LVCMOS33_S_12_HR
R14   GND   GND
R15   shield_dp26_dp41_tri_io[6]   LVCMOS33_S_12_HR
R16   shield_dp26_dp41_tri_io[8]   LVCMOS33_S_12_HR
R17   shield_dp0_dp19_tri_io[12]   LVCMOS33_S_12_HR
R18   shield_dp26_dp41_tri_io[13]   LVCMOS33_S_12_HR
T1   IO_L17N_T2_34   NC
T2   VCCO_34   POWER
T3   IO_L11N_T1_SRCC_34   NC
T4   IO_L12N_T1_MRCC_34   NC
T5   IO_L12P_T1_MRCC_34   NC
T6   IO_L23N_T3_34   NC
T7   GND   GND
T8   IO_L24N_T3_34   NC
T9   led_4bits_tri_o[2]   LVCMOS33_S_12_HR
T10   led_4bits_tri_o[3]   LVCMOS33_S_12_HR
T11   shield_dp0_dp19_tri_io[3]   LVCMOS33_S_12_HR
T12   VCCO_14   POWER
T13   A03_D19   LVCMOS25_F_8_HR
T14   shield_dp0_dp19_tri_io[5]   LVCMOS33_S_12_HR
T15   shield_dp0_dp19_tri_io[6]   LVCMOS33_S_12_HR
T16   shield_dp0_dp19_tri_io[7]   LVCMOS33_S_12_HR
T17   GND   GND
T18   shield_dp26_dp41_tri_io[12]   LVCMOS33_S_12_HR
U1   IO_L7P_T1_34   NC
U2   IO_L9P_T1_DQS_34   NC
U3   IO_L8N_T1_34   NC
U4   IO_L8P_T1_34   NC
U5   VCCO_34   POWER
U6   IO_L22N_T3_34   NC
U7   IO_L22P_T3_34   NC
U8   IO_25_34   NC
U9   IO_L21P_T3_DQS_34   NC
U10   GND   GND
U11   shield_dp26_dp41_tri_io[0]   LVCMOS33_S_12_HR
U12   A08_D24   LVCMOS25_F_8_HR
U13   A02_D18   LVCMOS25_F_8_HR
U14   A05_D21   LVCMOS25_F_8_HR
U15   VCCO_14   POWER
U16   shield_dp0_dp19_tri_io[1]   LVCMOS33_S_12_HR
U17   shield_dp26_dp41_tri_io[11]   LVCMOS33_S_12_HR
U18   shield_dp0_dp19_tri_io[11]   LVCMOS33_S_12_HR
V1   IO_L7N_T1_34   NC
V2   IO_L9N_T1_DQS_34   NC
V3   GND   GND
V4   IO_L10N_T1_34   NC
V5   IO_L10P_T1_34   NC
V6   IO_L20N_T3_34   NC
V7   IO_L20P_T3_34   NC
V8   VCCO_34   POWER
V9   IO_L21N_T3_DQS_34   NC
V10   IO_L21P_T3_DQS_14   NC
V11   A06_D22   LVCMOS25_F_8_HR
V12   A07_D23   LVCMOS25_F_8_HR
V13   GND   GND
V14   A04_D20   LVCMOS25_F_8_HR
V15   shield_dp0_dp19_tri_io[0]   LVCMOS33_S_12_HR
V16   shield_dp26_dp41_tri_io[1]   LVCMOS33_S_12_HR
V17   spi_ss_io   LVCMOS33_S_12_HR
V18   VCCO_14   POWER
[Package Model]   xc7a35t_csg324
[Diff Pin]   inv_pin   vdiff   tdelay_typ   tdelay_min   tdelay_max
[Define Package Model]   xc7a35t_csg324
[Manufacturer]   Xilinx Inc.
[OEM]   Xilinx
[Description]   324 ball organic wire-bond
|[Number of Sections]   1
[Number of Pins]   240
[Pin Numbers]
|[Pin Name]  Net Number   Net Name   Net's All Pins
F12   | 1   VCCAUX   F12
   |H12
   |K12
   |M12
F10   | 2   VCCBRAM   F10
   |G11
F8   | 3   VCCINT   F8
   |G7
   |G9
   |H8
   |J7
   |J11
   |K8
   |L7
   |L11
   |M8
   |M10
   |N7
   |N9
   |N11
R9   | 4   VCCO_0   R9
L17   | 5   VCCO_14   L17
   |N13
   |P16
   |T12
   |U15
   |V18
A17   | 6   VCCO_15   A17
   |C13
   |D16
   |G15
   |H18
   |K14
B10   | 7   VCCO_16   B10
K4   | 8   VCCO_34   K4
   |N3
   |P6
   |T2
   |U5
   |V8
A7   | 9   VCCO_35   A7
   |C3
   |D6
   |F2
   |G5
   |J1
E9   | 10   CCLK_0   E9
P8   | 11   CFGBVS_0   P8
P10   | 12   DONE_0   P10
L9   | 13   DXN_0   L9
L10   | 14   DXP_0   L10
H9   | 15   GNDADC_0   H9
P7   | 16   INIT_B_0   P7
R11   | 17   IO_0_14   R11
G13   | 18   IO_0_15   G13
K6   | 19   IO_0_34   K6
F5   | 20   IO_0_35   F5
R10   | 21   IO_25_14   R10
K16   | 22   IO_25_15   K16
U8   | 23   IO_25_34   U8
J5   | 24   IO_25_35   J5
M1   | 25   IO_L1N_T0_34   M1
C14   | 26   IO_L1N_T0_AD0N_15   C14
C5   | 27   IO_L1N_T0_AD4N_35   C5
K18   | 28   IO_L1N_T0_D01_DIN_14   K18
L1   | 29   IO_L1P_T0_34   L1
D14   | 30   IO_L1P_T0_AD0P_15   D14
C6   | 31   IO_L1P_T0_AD4P_35   C6
K17   | 32   IO_L1P_T0_D00_MOSI_14   K17
L3   | 33   IO_L2N_T0_34   L3
B14   | 34   IO_L2N_T0_AD8N_15   B14
B6   | 35   IO_L2N_T0_AD12N_35   B6
M14   | 36   IO_L2N_T0_D03_14   M14
K3   | 37   IO_L2P_T0_34   K3
B13   | 38   IO_L2P_T0_AD8P_15   B13
B7   | 39   IO_L2P_T0_AD12P_35   B7
L14   | 40   IO_L2P_T0_D02_14   L14
N1   | 41   IO_L3N_T0_DQS_34   N1
B12   | 42   IO_L3N_T0_DQS_AD1N_15   B12
A5   | 43   IO_L3N_T0_DQS_AD5N_35   A5
L16   | 44   IO_L3N_T0_DQS_EMCCLK_14   L16
N2   | 45   IO_L3P_T0_DQS_34   N2
C12   | 46   IO_L3P_T0_DQS_AD1P_15   C12
A6   | 47   IO_L3P_T0_DQS_AD5P_35   A6
L15   | 48   IO_L3P_T0_DQS_PUDC_B_14   L15
A11   | 49   IO_L4N_T0_15   A11
M2   | 50   IO_L4N_T0_34   M2
C7   | 51   IO_L4N_T0_35   C7
M18   | 52   IO_L4N_T0_D05_14   M18
B11   | 53   IO_L4P_T0_15   B11
M3   | 54   IO_L4P_T0_34   M3
D8   | 55   IO_L4P_T0_35   D8
L18   | 56   IO_L4P_T0_D04_14   L18
L4   | 57   IO_L5N_T0_34   L4
F14   | 58   IO_L5N_T0_AD9N_15   F14
E5   | 59   IO_L5N_T0_AD13N_35   E5
R13   | 60   IO_L5N_T0_D07_14   R13
K5   | 61   IO_L5P_T0_34   K5
F13   | 62   IO_L5P_T0_AD9P_15   F13
E6   | 63   IO_L5P_T0_AD13P_35   E6
R12   | 64   IO_L5P_T0_D06_14   R12
M13   | 65   IO_L6N_T0_D08_VREF_14   M13
D13   | 66   IO_L6N_T0_VREF_15   D13
D9   | 67   IO_L6N_T0_VREF_16   D9
L5   | 68   IO_L6N_T0_VREF_34   L5
D7   | 69   IO_L6N_T0_VREF_35   D7
D12   | 70   IO_L6P_T0_15   D12
L6   | 71   IO_L6P_T0_34   L6
E7   | 72   IO_L6P_T0_35   E7
L13   | 73   IO_L6P_T0_FCS_B_14   L13
V1   | 74   IO_L7N_T1_34   V1
B17   | 75   IO_L7N_T1_AD2N_15   B17
B4   | 76   IO_L7N_T1_AD6N_35   B4
T18   | 77   IO_L7N_T1_D10_14   T18
U1   | 78   IO_L7P_T1_34   U1
B16   | 79   IO_L7P_T1_AD2P_15   B16
C4   | 80   IO_L7P_T1_AD6P_35   C4
R18   | 81   IO_L7P_T1_D09_14   R18
U3   | 82   IO_L8N_T1_34   U3
A16   | 83   IO_L8N_T1_AD10N_15   A16
A3   | 84   IO_L8N_T1_AD14N_35   A3
P14   | 85   IO_L8N_T1_D12_14   P14
U4   | 86   IO_L8P_T1_34   U4
A15   | 87   IO_L8P_T1_AD10P_15   A15
A4   | 88   IO_L8P_T1_AD14P_35   A4
N14   | 89   IO_L8P_T1_D11_14   N14
V2   | 90   IO_L9N_T1_DQS_34   V2
A14   | 91   IO_L9N_T1_DQS_AD3N_15   A14
A1   | 92   IO_L9N_T1_DQS_AD7N_35   A1
P18   | 93   IO_L9N_T1_DQS_D13_14   P18
N17   | 94   IO_L9P_T1_DQS_14   N17
U2   | 95   IO_L9P_T1_DQS_34   U2
A13   | 96   IO_L9P_T1_DQS_AD3P_15   A13
B1   | 97   IO_L9P_T1_DQS_AD7P_35   B1
V4   | 98   IO_L10N_T1_34   V4
A18   | 99   IO_L10N_T1_AD11N_15   A18
B2   | 100   IO_L10N_T1_AD15N_35   B2
M17   | 101   IO_L10N_T1_D15_14   M17
V5   | 102   IO_L10P_T1_34   V5
B18   | 103   IO_L10P_T1_AD11P_15   B18
B3   | 104   IO_L10P_T1_AD15P_35   B3
M16   | 105   IO_L10P_T1_D14_14   M16
N16   | 106   IO_L11N_T1_SRCC_14   N16
E16   | 107   IO_L11N_T1_SRCC_15   E16
B9   | 108   IO_L11N_T1_SRCC_16   B9
T3   | 109   IO_L11N_T1_SRCC_34   T3
D4   | 110   IO_L11N_T1_SRCC_35   D4
N15   | 111   IO_L11P_T1_SRCC_14   N15
E15   | 112   IO_L11P_T1_SRCC_15   E15
C9   | 113   IO_L11P_T1_SRCC_16   C9
R3   | 114   IO_L11P_T1_SRCC_34   R3
D5   | 115   IO_L11P_T1_SRCC_35   D5
R17   | 116   IO_L12N_T1_MRCC_14   R17
C15   | 117   IO_L12N_T1_MRCC_15   C15
A8   | 118   IO_L12N_T1_MRCC_16   A8
T4   | 119   IO_L12N_T1_MRCC_34   T4
D3   | 120   IO_L12N_T1_MRCC_35   D3
P17   | 121   IO_L12P_T1_MRCC_14   P17
D15   | 122   IO_L12P_T1_MRCC_15   D15
B8   | 123   IO_L12P_T1_MRCC_16   B8
T5   | 124   IO_L12P_T1_MRCC_34   T5
E3   | 125   IO_L12P_T1_MRCC_35   E3
R15   | 126   IO_L13N_T2_MRCC_14   R15
G16   | 127   IO_L13N_T2_MRCC_15   G16
C10   | 128   IO_L13N_T2_MRCC_16   C10
P5   | 129   IO_L13N_T2_MRCC_34   P5
F3   | 130   IO_L13N_T2_MRCC_35   F3
P15   | 131   IO_L13P_T2_MRCC_14   P15
H16   | 132   IO_L13P_T2_MRCC_15   H16
C11   | 133   IO_L13P_T2_MRCC_16   C11
N5   | 134   IO_L13P_T2_MRCC_34   N5
F4   | 135   IO_L13P_T2_MRCC_35   F4
T15   | 136   IO_L14N_T2_SRCC_14   T15
F16   | 137   IO_L14N_T2_SRCC_15   F16
A9   | 138   IO_L14N_T2_SRCC_16   A9
P3   | 139   IO_L14N_T2_SRCC_34   P3
D2   | 140   IO_L14N_T2_SRCC_35   D2
T14   | 141   IO_L14P_T2_SRCC_14   T14
F15   | 142   IO_L14P_T2_SRCC_15   F15
A10   | 143   IO_L14P_T2_SRCC_16   A10
P4   | 144   IO_L14P_T2_SRCC_34   P4
E2   | 145   IO_L14P_T2_SRCC_35   E2
R2   | 146   IO_L15N_T2_DQS_34   R2
G2   | 147   IO_L15N_T2_DQS_35   G2
G14   | 148   IO_L15N_T2_DQS_ADV_B_15   G14
T16   | 149   IO_L15N_T2_DQS_DOUT_CSO_B_14   T16
H14   | 150   IO_L15P_T2_DQS_15   H14
P2   | 151   IO_L15P_T2_DQS_34   P2
H2   | 152   IO_L15P_T2_DQS_35   H2
R16   | 153   IO_L15P_T2_DQS_RDWR_B_14   R16
N4   | 154   IO_L16N_T2_34   N4
C1   | 155   IO_L16N_T2_35   C1
V16   | 156   IO_L16N_T2_A15_D31_14   V16
D17   | 157   IO_L16N_T2_A27_15   D17
M4   | 158   IO_L16P_T2_34   M4
C2   | 159   IO_L16P_T2_35   C2
E17   | 160   IO_L16P_T2_A28_15   E17
V15   | 161   IO_L16P_T2_CSI_B_14   V15
T1   | 162   IO_L17N_T2_34   T1
G1   | 163   IO_L17N_T2_35   G1
U18   | 164   IO_L17N_T2_A13_D29_14   U18
J13   | 165   IO_L17N_T2_A25_15   J13
R1   | 166   IO_L17P_T2_34   R1
H1   | 167   IO_L17P_T2_35   H1
U17   | 168   IO_L17P_T2_A14_D30_14   U17
K13   | 169   IO_L17P_T2_A26_15   K13
N6   | 170   IO_L18N_T2_34   N6
E1   | 171   IO_L18N_T2_35   E1
V17   | 172   IO_L18N_T2_A11_D27_14   V17
G17   | 173   IO_L18N_T2_A23_15   G17
M6   | 174   IO_L18P_T2_34   M6
F1   | 175   IO_L18P_T2_35   F1
U16   | 176   IO_L18P_T2_A12_D28_14   U16
H17   | 177   IO_L18P_T2_A24_15   H17
U11   | 178   IO_L19N_T3_A09_D25_VREF_14   U11
H15   | 179   IO_L19N_T3_A21_VREF_15   H15
D10   | 180   IO_L19N_T3_VREF_16   D10
R5   | 181   IO_L19N_T3_VREF_34   R5
F6   | 182   IO_L19N_T3_VREF_35   F6
R6   | 183   IO_L19P_T3_34   R6
G6   | 184   IO_L19P_T3_35   G6
T11   | 185   IO_L19P_T3_A10_D26_14   T11
J14   | 186   IO_L19P_T3_A22_15   J14
V6   | 187   IO_L20N_T3_34   V6
G3   | 188   IO_L20N_T3_35   G3
V12   | 189   IO_L20N_T3_A07_D23_14   V12
C17   | 190   IO_L20N_T3_A19_15   C17
V7   | 191   IO_L20P_T3_34   V7
G4   | 192   IO_L20P_T3_35   G4
U12   | 193   IO_L20P_T3_A08_D24_14   U12
C16   | 194   IO_L20P_T3_A20_15   C16
V9   | 195   IO_L21N_T3_DQS_34   V9
H4   | 196   IO_L21N_T3_DQS_35   H4
V11   | 197   IO_L21N_T3_DQS_A06_D22_14   V11
D18   | 198   IO_L21N_T3_DQS_A18_15   D18
V10   | 199   IO_L21P_T3_DQS_14   V10
E18   | 200   IO_L21P_T3_DQS_15   E18
U9   | 201   IO_L21P_T3_DQS_34   U9
J4   | 202   IO_L21P_T3_DQS_35   J4
U6   | 203   IO_L22N_T3_34   U6
J2   | 204   IO_L22N_T3_35   J2
V14   | 205   IO_L22N_T3_A04_D20_14   V14
F18   | 206   IO_L22N_T3_A16_15   F18
U7   | 207   IO_L22P_T3_34   U7
J3   | 208   IO_L22P_T3_35   J3
U14   | 209   IO_L22P_T3_A05_D21_14   U14
G18   | 210   IO_L22P_T3_A17_15   G18
T6   | 211   IO_L23N_T3_34   T6
K1   | 212   IO_L23N_T3_35   K1
U13   | 213   IO_L23N_T3_A02_D18_14   U13
J18   | 214   IO_L23N_T3_FWE_B_15   J18
R7   | 215   IO_L23P_T3_34   R7
K2   | 216   IO_L23P_T3_35   K2
T13   | 217   IO_L23P_T3_A03_D19_14   T13
J17   | 218   IO_L23P_T3_FOE_B_15   J17
T8   | 219   IO_L24N_T3_34   T8
H5   | 220   IO_L24N_T3_35   H5
T10   | 221   IO_L24N_T3_A00_D16_14   T10
J15   | 222   IO_L24N_T3_RS0_15   J15
R8   | 223   IO_L24P_T3_34   R8
H6   | 224   IO_L24P_T3_35   H6
T9   | 225   IO_L24P_T3_A01_D17_14   T9
K15   | 226   IO_L24P_T3_RS1_15   K15
P12   | 227   M0_0   P12
P13   | 228   M1_0   P13
P11   | 229   M2_0   P11
P9   | 230   PROGRAM_B_0   P9
E10   | 231   TCK_0   E10
E11   | 232   TDI_0   E11
E13   | 233   TDO_0   E13
E12   | 234   TMS_0   E12
H10   | 235   VCCADC_0   H10
E8   | 236   VCCBATT_0   E8
K9   | 237   VN_0   K9
J10   | 238   VP_0   J10
J9   | 239   VREFN_0   J9
K10   | 240   VREFP_0   K10
[Model Data]
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[End Model Data]
[End Package Model]
[Model]   rterm_dt_hr
Model_type   Series
|   (typ)   (min)   (max)
C_comp   0.0000pF   0.0000pF   0.0000pF
[Temperature Range]   25.0000   85.0000   0.0
[Voltage Range]   2.5000V   2.3750V   2.6250V
[R Series]   77.8408   97.4321   61.2294
|End [Model] rterm_dt_hr
| Models and submodels in the file (160): BLVDS_25_HR (I/O), HSTL_II_18_F_HR (I/O), HSTL_II_18_F_HR_IN40 (I/O), HSTL_II_18_F_HR_IN50 (I/O), HSTL_II_18_F_HR_IN60 (I/O), HSTL_II_18_S_HR (I/O), HSTL_II_18_S_HR_IN40 (I/O), HSTL_II_18_S_HR_IN50 (I/O), HSTL_II_18_S_HR_IN60 (I/O), HSTL_II_F_HR (I/O), HSTL_II_F_HR_IN40 (I/O), HSTL_II_F_HR_IN50 (I/O), HSTL_II_F_HR_IN60 (I/O), HSTL_II_S_HR (I/O), HSTL_II_S_HR_IN40 (I/O), HSTL_II_S_HR_IN50 (I/O), HSTL_II_S_HR_IN60 (I/O), HSTL_I_18_F_HR (I/O), HSTL_I_18_F_HR_IN40 (I/O), HSTL_I_18_F_HR_IN50 (I/O), HSTL_I_18_F_HR_IN60 (I/O), HSTL_I_18_S_HR (I/O), HSTL_I_18_S_HR_IN40 (I/O), HSTL_I_18_S_HR_IN50 (I/O), HSTL_I_18_S_HR_IN60 (I/O), HSTL_I_F_HR (I/O), HSTL_I_F_HR_IN40 (I/O), HSTL_I_F_HR_IN50 (I/O), HSTL_I_F_HR_IN60 (I/O), HSTL_I_S_HR (I/O), HSTL_I_S_HR_IN40 (I/O), HSTL_I_S_HR_IN50 (I/O), HSTL_I_S_HR_IN60 (I/O), HSUL_12_F_HR (I/O), HSUL_12_S_HR (I/O), IN40_1V35 (Dynamic_clamp), IN40_1V5 (Dynamic_clamp), IN40_1V8 (Dynamic_clamp), IN50_1V35 (Dynamic_clamp), IN50_1V5 (Dynamic_clamp), IN50_1V8 (Dynamic_clamp), IN60_1V35 (Dynamic_clamp), IN60_1V5 (Dynamic_clamp), IN60_1V8 (Dynamic_clamp), LVCMOS12_F_12_HR (I/O), LVCMOS12_F_4_HR (I/O), LVCMOS12_F_8_HR (I/O), LVCMOS12_S_12_HR (I/O), LVCMOS12_S_4_HR (I/O), LVCMOS12_S_8_HR (I/O), LVCMOS15_F_12_HR (I/O), LVCMOS15_F_16_HR (I/O), LVCMOS15_F_4_HR (I/O), LVCMOS15_F_8_HR (I/O), LVCMOS15_S_12_HR (I/O), LVCMOS15_S_16_HR (I/O), LVCMOS15_S_4_HR (I/O), LVCMOS15_S_8_HR (I/O), LVCMOS18_F_12_HR (I/O), LVCMOS18_F_16_HR (I/O), LVCMOS18_F_24_HR (I/O), LVCMOS18_F_4_HR (I/O), LVCMOS18_F_8_HR (I/O), LVCMOS18_S_12_HR (I/O), LVCMOS18_S_16_HR (I/O), LVCMOS18_S_24_HR (I/O), LVCMOS18_S_4_HR (I/O), LVCMOS18_S_8_HR (I/O), LVCMOS25_F_12_HR (I/O), LVCMOS25_F_16_HR (I/O), LVCMOS25_F_4_HR (I/O), LVCMOS25_F_8_HR (I/O), LVCMOS25_S_12_HR (I/O), LVCMOS25_S_16_HR (I/O), LVCMOS25_S_4_HR (I/O), LVCMOS25_S_8_HR (I/O), LVCMOS33_F_12_HR (I/O), LVCMOS33_F_16_HR (I/O), LVCMOS33_F_4_HR (I/O), LVCMOS33_F_8_HR (I/O)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
